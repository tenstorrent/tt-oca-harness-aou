// *****************************************************************************
// SPDX-License-Identifier: Apache-2.0
// *****************************************************************************
//  Copyright (c) 2026 Tenstorrent USA Inc
//
//  Licensed under the Apache License, Version 2.0 (the "License");
//  you may not use this file except in compliance with the License.
//  You may obtain a copy of the License at
//
//      http://www.apache.org/licenses/LICENSE-2.0
//
//  Unless required by applicable law or agreed to in writing, software
//  distributed under the License is distributed on an "AS IS" BASIS,
//  WITHOUT WARRANTIES OR CONDITIONS OF ANY KIND, either express or implied.
//  See the License for the specific language governing permissions and
//  limitations under the License.
// *****************************************************************************
// Generated from RTL/AOU_CORE_SFR.v - AOU Core Special Function Registers
// *****************************************************************************

addrmap aou_core {
    name = "AOU Core Control and Status Registers";
    desc = "Register map for AOU_CORE_SFR (APB slave). Addresses match RTL localparams. Fields with sw=r and no reset are driven by module inputs (I_*), connected in AOU_CORE.sv; stored fields (flops) have the stated reset.";

    // -------------------------------------------------------------------------
    // IP Version (RO) - tied off in AOU_CORE.sv: major=16'd1, minor=16'b0
    // -------------------------------------------------------------------------
    reg {
        regwidth = 32;
        name = "IP Version";
        desc = "IP version; read-only. Tied off in AOU_CORE.sv (u_aou_core_sfr): I_IP_VERSION_MAJOR_VERSION=16'd1, I_IP_VERSION_MINOR_VERSION=16'b0.";
        field { sw = r; hw = w; desc = "IP major version number."; } major_version[31:16] = 16'd1;
        field { sw = r; hw = w; desc = "IP minor version number."; } minor_version[15:0] = 16'b0;
    } ip_version @ 0x0000;

    // -------------------------------------------------------------------------
    // AOU Control 0
    // -------------------------------------------------------------------------
    reg {
        regwidth = 32;
        name = "AOU Control 0";
        desc = "Core control: error access, AXI aggregator, LP mode, reset, credit, split. Note: bits [1:0] read as 0 in RTL (deactivate_force is not read back).";
        field { sw = r; } reserved_31_28[31:28] = 0;
        field { sw = rw; desc = "Enable error information access for Resource Plane 3."; } rp3_error_info_access_en[27:27] = 0;
        field { sw = rw; desc = "Enable error information access for Resource Plane 2."; } rp2_error_info_access_en[26:26] = 0;
        field { sw = rw; desc = "Enable error information access for Resource Plane 1."; } rp1_error_info_access_en[25:25] = 0;
        field { sw = rw; desc = "Enable error information access for Resource Plane 0."; } rp0_error_info_access_en[24:24] = 0;
        field { sw = rw; desc = "Enable AXI aggregator for RP3. When set, narrow read and write data are combined to improve bus utilization (e.g., 256-bit size with burst length 16 becomes 1024-bit size with burst length 4). Can be configured independently per RP."; } rp3_axi_aggregator_en[23:23] = 0;
        field { sw = rw; desc = "Enable AXI aggregator for RP2. When set, narrow read and write data are combined to improve bus utilization."; } rp2_axi_aggregator_en[22:22] = 0;
        field { sw = rw; desc = "Enable AXI aggregator for RP1. When set, narrow read and write data are combined to improve bus utilization."; } rp1_axi_aggregator_en[21:21] = 0;
        field { sw = rw; desc = "Enable AXI aggregator for RP0. When set, narrow read and write data are combined to improve bus utilization."; } rp0_axi_aggregator_en[20:20] = 0;
        field { sw = rw; desc = "TX low-power mode message transmission frequency. Only meaningful when tx_lp_mode is enabled. When non-zero (legacy behavior), and only activation messages are pending (no AXI traffic), the TX will wait this many cycles before sending a partially-filled heartbeat flit; configures the trade-off between latency and power. When set to 0, the threshold is inert: the TX emits no idle/heartbeat flits and only launches a flit when there is real work to send (AXI traffic, CrdtGrant credit-return messages in the ring buffer, or pending MsgCredit-header credits). Once a flit is started it always finishes; unused granule slots are zero-padded. Static configuration, programmed together with tx_lp_mode and under the same rule: change it only while the activation FSM is DISABLED (ACTIVATE_STATE_DISABLED = 1), never while the link is activating, ENABLED or deactivating."; } tx_lp_mode_threshold[19:12] = 0x4;
        field { sw = rw; desc = "TX low-power mode enable. When set to 1, AOU_CORE only sends payload to FDI when there are remaining AXI messages to send. Credit-only flit behavior is gated by tx_lp_mode_threshold: non-zero threshold preserves the legacy heartbeat (a partially-filled flit every threshold+1 cycles while the link is active); a zero threshold disables the heartbeat entirely so the TX only emits flits when AXI traffic is pending or credits need to be returned. When 0 (default), AOU_CORE always sends messages to FDI for lowest latency. Static configuration: program it only while the activation FSM is DISABLED (ACTIVATE_STATE_DISABLED = 1), before ACTIVATE_START or after a deactivation has completed. It must not be changed while the link is activating, ENABLED or deactivating: the TX core may be mid-flit, and the flit is not preserved across a change of mode."; } tx_lp_mode[11:11] = 0;
        field { sw = r; } reserved_10_5[10:5] = 0;
        field { sw = w; hw = rw; desc = "Software reset of AOU_CORE. Writing 1 resets AOU_CORE the way I_RESETN does: every SFR (this bit included) returns to its reset value, the activation FSM returns to DISABLED, the RX FIFOs of every RP are emptied and the AXI port logic is cleared; a transaction in flight or queued is lost and gets no response. Write-only; reads return 0 (the reset clears the bit itself, so the reset lasts one I_CLK cycle). Use it only as part of the LinkReset handling sequence (MAS 7.3.6), with the FDI link down: in LinkError (the AOU_TOP bringup controller holds the link there until this reset is written), LinkReset, Disabled or Reset, never Active."; } aou_sw_reset[4:4] = 0;
        field { sw = r; } reserved_3[3:3] = 0;
        field { sw = rw; desc = "Global enable for AXI split transaction feature."; } axi_split_tr_en[2:2] = 0;
        field { sw = r; } reserved_1[1:1] = 0;
        field { sw = w; hw = rw; desc = "Force deactivation of the AoU protocol interface. Write-only; reads return 0. Self-clears when activate_state_disabled asserts."; } deactivate_force[0:0] = 0;
    } aou_con0 @ 0x0004;

    // -------------------------------------------------------------------------
    // AOU Init (control and status) - [11],[10],[9],[3],[2] from I_* input wires
    // -------------------------------------------------------------------------
    reg {
        regwidth = 32;
        name = "AOU Init";
        desc = "Activate/deactivate control; status from HW. int_deactivate_property, mst_tr_complete, slv_tr_complete, activate_state_disabled, activate_state_enabled are read-only inputs (I_*), driven in AOU_CORE.sv from internal/output signals. Write 1 to clear int_fdi_link_down/int_activate_start/int_deactivate_start.";
        field { sw = r; } reserved_31_13[31:13] = 0;
        field { sw = rw; hw = rw; onwrite = woclr; desc = "FDI link lost with AoU in use. Set by HW on the falling edge of I_INT_FSM_IN_ACTIVE (the FDI bring-up controller left Active for LinkError, LinkReset, Disabled or Reset; Retrain and L1 do not count) while the activation FSM is in ACTIVATE, ENABLED or DEACTIVATE, or in DISABLED with an ActivateReq already sent or received (its entry to ACTIVATE is cancelled). The activation FSM returns to DISABLED. Write 1 to clear. Source of INT_FDI_LINK_DOWN."; } int_fdi_link_down[12:12] = 0;
        field { sw = r; hw = w; desc = "Deactivation property status. Read-only, driven by HW."; } int_deactivate_property[11:11];
        field { sw = r; hw = w; desc = "Master transaction completion status. Read-only, driven by HW."; } mst_tr_complete[10:10];
        field { sw = r; hw = w; desc = "Slave transaction completion status. Read-only, driven by HW."; } slv_tr_complete[9:9];
        field { sw = rw; hw = rw; onwrite = woclr; desc = "Activation start interrupt status. Set by HW, write 1 to clear."; } int_activate_start[8:8] = 0;
        field { sw = rw; hw = rw; onwrite = woclr; desc = "Deactivation start interrupt status. Set by HW, write 1 to clear."; } int_deactivate_start[7:7] = 0;
        field { sw = rw; desc = "Quiet window before DeactivateReq, in core clock cycles: 2^(value + 3), so 8, 16, 32, 64, 128, 256, 512 or 1024 (reset 0 is 8). The window runs while the activation FSM is ENABLED or DEACTIVATE and restarts whenever the TX path has a message to send; it is held clear in DISABLED and ACTIVATE. It may already have elapsed when DEACTIVATE_START is written, in which case DeactivateReq follows at once, subject to the other deactivation conditions. See MAS 7.1."; } deactivate_time_out_value[6:4] = 0;
        field { sw = r; hw = w; desc = "Indicates the AoU activation FSM is in the DISABLED state. Read-only, driven by HW."; } activate_state_disabled[3:3];
        field { sw = r; hw = w; desc = "Indicates the AoU activation FSM is in the ENABLED state. Read-only, driven by HW."; } activate_state_enabled[2:2];
        field { sw = rw; hw = rw; desc = "Write 1 to initiate AoU protocol deactivation. Self-clears when activate_state_disabled asserts."; } deactivate_start[1:1] = 0;
        field { sw = rw; hw = rw; desc = "Write 1 to initiate AoU protocol activation. Self-clears when activate_state_enabled asserts."; } activate_start[0:0] = 0;
    } aou_init @ 0x0008;

    // -------------------------------------------------------------------------
    // AOU Interrupt Mask
    // -------------------------------------------------------------------------
    reg {
        regwidth = 32;
        name = "AOU Interrupt Mask";
        desc = "Interrupt mask bits for linkreset, early response and FDI link-down interrupts. Write 1 to mask the corresponding interrupt source.";
        field { sw = r; } reserved_31_11[31:11] = 0;
        field { sw = rw; desc = "Mask bit for the FDI link-down interrupt (INT_FDI_LINK_DOWN)."; } int_fdi_link_down_mask[10:10] = 0;
        field { sw = rw; desc = "Mask bit for the early-response write-transaction watchdog interrupt (INT_EARLY_WDT_ERR)."; } int_early_wdt_mask[9:9] = 0;
        field { sw = rw; desc = "Mask bit for activation ACK timeout link reset interrupt."; } int_req_linkreset_act_ack_mask[8:8] = 0;
        field { sw = rw; desc = "Mask bit for deactivation ACK timeout link reset interrupt."; } int_req_linkreset_deact_ack_mask[7:7] = 0;
        field { sw = rw; desc = "Mask bit for invalid activation message link reset interrupt."; } int_req_linkreset_invalid_actmsg_mask[6:6] = 0;
        field { sw = rw; desc = "Mask bit for message credit timeout link reset interrupt."; } int_req_linkreset_msgcredit_timeout_mask[5:5] = 0;
        field { sw = rw; desc = "Mask bit for early write response error interrupt."; } int_early_resp_mask[4:4] = 0;
        field { sw = rw; desc = "Mask bit for master interface 0 ID mismatch interrupt."; } int_mi0_id_mismatch_mask[3:3] = 0;
        field { sw = rw; desc = "Mask bit for slave interface 0 ID mismatch interrupt."; } int_si0_id_mismatch_mask[2:2] = 0;
        field { sw = r; } reserved_1_0[1:0] = 0;
    } aou_interrupt_mask @ 0x000C;

    // -------------------------------------------------------------------------
    // LP Linkreset (timeouts and status; write 1 to clear error bits)
    // -------------------------------------------------------------------------
    reg {
        regwidth = 32;
        name = "LP Linkreset";
        desc = "ACK/MSG credit timeouts; error status (w1c).";
        field { sw = r; } reserved_31_14[31:14] = 0;
        field { sw = rw; desc = "Activation/deactivation ACK timeout threshold."; } ack_time_out_value[13:11] = 0x4;
        field { sw = rw; desc = "Message credit timeout threshold."; } msgcredit_time_out_value[10:8] = 0x4;
        field { sw = rw; hw = w; onwrite = woclr; desc = "Activation ACK timeout error. Set by HW, write 1 to clear."; } act_ack_err[7:7] = 0;
        field { sw = rw; hw = w; onwrite = woclr; desc = "Deactivation ACK timeout error. Set by HW, write 1 to clear."; } deact_ack_err[6:6] = 0;
        field { sw = r; hw = rw; desc = "Captured activation message info when invalid_actmsg_err is set. Clears when error clears."; } invalid_actmsg_info[5:2] = 0;
        field { sw = rw; hw = w; onwrite = woclr; desc = "Invalid activation message error. Set by HW, write 1 to clear."; } invalid_actmsg_err[1:1] = 0;
        field { sw = rw; hw = w; onwrite = woclr; desc = "Message credit timeout error. Set by HW, write 1 to clear."; } msgcredit_err[0:0] = 0;
    } lp_linkreset @ 0x0010;

    // -------------------------------------------------------------------------
    // Destination RP
    // -------------------------------------------------------------------------
    reg {
        regwidth = 32;
        name = "Destination RP";
        desc = "Destination Resource Plane mapping for outgoing messages on each RP.";
        field { sw = r; } reserved_31_14[31:14] = 0;
        field { sw = rw; desc = "Destination Resource Plane mapping for RP3."; } rp3_dest[13:12] = 0x3;
        field { sw = r; } reserved_11_10[11:10] = 0;
        field { sw = rw; desc = "Destination Resource Plane mapping for RP2."; } rp2_dest[9:8] = 0x2;
        field { sw = r; } reserved_7_6[7:6] = 0;
        field { sw = rw; desc = "Destination Resource Plane mapping for RP1."; } rp1_dest[5:4] = 0x1;
        field { sw = r; } reserved_3_2[3:2] = 0;
        field { sw = rw; desc = "Destination Resource Plane mapping for RP0."; } rp0_dest[1:0] = 0x0;
    } dest_rp @ 0x0014;

    // -------------------------------------------------------------------------
    // Priority RP AXI
    // -------------------------------------------------------------------------
    reg {
        regwidth = 32;
        name = "Priority RP AXI";
        desc = "QoS thresholds, per-RP priority levels, and arbitration mode for the TX AW and AR request arbiters. Program this register before the link is activated. It may be written in mission mode, but the arbitration of requests already accepted or in flight is then not guaranteed.";
        field { sw = r; } reserved_31_28[31:28] = 0;
        field { sw = rw; desc = "AXI QoS to normal priority boundary. In AXI QoS arbitration mode (arb_mode=2) the classifier tests axi_qos_to_hp first: a QoS value at or above axi_qos_to_hp is high priority. Otherwise a value at or above this threshold is normal priority, and a value below it is low priority. axi_qos_to_hp must be greater than this field. If it is not, the normal tier is empty."; } axi_qos_to_np[27:24] = 0x5;
        field { sw = rw; desc = "AXI QoS to high priority boundary. In AXI QoS arbitration mode (arb_mode=2) this threshold is tested before axi_qos_to_np. A QoS value at or above this threshold is high priority, including when it is also at or above axi_qos_to_np. A value at or above axi_qos_to_np and below this threshold is normal priority. This field must be greater than axi_qos_to_np; otherwise the normal tier is empty and every value at or above this threshold is high."; } axi_qos_to_hp[23:20] = 0xA;
        field { sw = r; } reserved_19_18[19:18] = 0;
        field { sw = rw; desc = "Priority level for Resource Plane 3 in Port QoS arbitration mode (arb_mode=1): 3 = high, 2 = normal, 1 = low; 0 is treated as 1 (low)."; } rp3_prior[17:16] = 0x3;
        field { sw = r; } reserved_15_14[15:14] = 0;
        field { sw = rw; desc = "Priority level for Resource Plane 2 in Port QoS arbitration mode (arb_mode=1): 3 = high, 2 = normal, 1 = low; 0 is treated as 1 (low)."; } rp2_prior[13:12] = 0x2;
        field { sw = r; } reserved_11_10[11:10] = 0;
        field { sw = rw; desc = "Priority level for Resource Plane 1 in Port QoS arbitration mode (arb_mode=1): 3 = high, 2 = normal, 1 = low; 0 is treated as 1 (low)."; } rp1_prior[9:8] = 0x1;
        field { sw = r; } reserved_7_6[7:6] = 0;
        field { sw = rw; desc = "Priority level for Resource Plane 0 in Port QoS arbitration mode (arb_mode=1): 3 = high, 2 = normal, 1 = low; 0 is treated as 1 (low). The reset value 0 makes RP0 low priority."; } rp0_prior[5:4] = 0x0;
        field { sw = r; } reserved_3_2[3:2] = 0;
        field { sw = rw; desc = "TX arbitration mode between RPs on the AW and AR channels. W data is sent in the order of the granted AWs; B and R responses are arbitrated round-robin regardless of this field. 0: Round-Robin between valid RPs. 1: Port QoS, priority is set per-RP via the rp*_prior fields (3 levels: high/normal/low). 2: AXI QoS, priority is derived from the AXI AxQOS value with boundaries set by axi_qos_to_hp and axi_qos_to_np. 3: reserved, behaves as Round-Robin. In Port QoS and AXI QoS modes the highest tier present is served first and RPs at the same tier are served round-robin; the prior_timer starvation-prevention timeout promotes waiting normal and low priority requests to high priority."; } arb_mode[1:0] = 0;
    } prior_rp_axi @ 0x0018;

    // -------------------------------------------------------------------------
    // Priority Timer
    // -------------------------------------------------------------------------
    reg {
        regwidth = 32;
        name = "Priority Timer";
        desc = "Starvation-prevention timer for the Port QoS and AXI QoS arbitration modes (prior_rp_axi.arb_mode 1 or 2). Each per-RP TX request buffer (one per RP for AW and one per RP for AR) has a 16-bit prescaler that ticks once every timer_resolution + 1 clock cycles while the buffer holds at least one request, and holds its count while the buffer is empty. Every normal or low priority request in the buffer counts ticks from the cycle it is accepted; when its count reaches timer_threshold it is arbitrated as high priority. The prescaler is shared by the requests in a buffer and is not restarted when a request arrives, so the first tick a request sees comes 1 to timer_resolution + 1 cycles after acceptance. At the reset values a request is promoted about 225 to 240 cycles after acceptance. The timer runs in Round-Robin mode but has no effect there. Program this register before the link is activated. It may be written in mission mode, but the promotion of requests already waiting is then not guaranteed.";
        field { sw = rw; desc = "Priority timer resolution: prescaler period minus one, in clock cycles. The prescaler ticks once every timer_resolution + 1 cycles; 0 ticks every cycle and 0xFFFF every 65536 cycles."; } timer_resolution[31:16] = 0xF;
        field { sw = rw; desc = "Priority timer threshold: the number of prescaler ticks a normal or low priority request waits before it is arbitrated as high priority. Counted from acceptance into the TX request buffer, not from reaching the head of the buffer; the count saturates at this value. 0 promotes every normal and low priority request at once, so all requests arbitrate as high priority and the result is round-robin."; } timer_threshold[15:0] = 0xF;
    } prior_timer @ 0x001C;

    // -------------------------------------------------------------------------
    // RP0: AXI Split Transaction
    // -------------------------------------------------------------------------
    reg {
        regwidth = 32;
        name = "AXI Split Transaction RP0";
        desc = "Maximum AXI burst lengths for split transactions on Resource Plane 0.";
        field { sw = r; } reserved_31_16[31:16] = 0;
        field { sw = rw; desc = "Maximum AXI write burst length for split transactions on RP0. Legal values are 2^n - 1: 0, 1, 3, 7, 15, 31, 63, 127, 255. Any other written value is stored as 0xF (16 beats)."; } max_awburstlen[15:8] = 0xF;
        field { sw = rw; desc = "Maximum AXI read burst length for split transactions on RP0. Legal values are 2^n - 1: 0, 1, 3, 7, 15, 31, 63, 127, 255. Any other written value is stored as 0xF (16 beats)."; } max_arburstlen[7:0] = 0xF;
    } axi_split_tr_rp0 @ 0x0020;

    reg {
        regwidth = 32;
        name = "Error Info RP0";
        desc = "Split transaction BID/RID mismatch info and error flags for RP0.";
        field { sw = r; } reserved_31_22[31:22] = 0;
        field { sw = r; hw = rw; desc = "Captured BID when a split transaction BID mismatch occurs. Clears when error clears."; } split_bid_mismatch_info[21:12];
        field { sw = r; hw = rw; desc = "Captured RID when a split transaction RID mismatch occurs. Clears when error clears."; } split_rid_mismatch_info[11:2];
        field { sw = rw; hw = w; onwrite = woclr; desc = "Split transaction BID mismatch error. Set by HW, write 1 to clear."; } split_bid_mismatch_err[1:1] = 0;
        field { sw = rw; hw = w; onwrite = woclr; desc = "Split transaction RID mismatch error. Set by HW, write 1 to clear."; } split_rid_mismatch_err[0:0] = 0;
    } error_info_rp0 @ 0x0024;

    reg {
        regwidth = 32;
        name = "Write Early Response RP0";
        desc = "Write response done/error status, early BRESP enable and write-transaction watchdog control for RP0.";
        field { sw = r; } reserved_31_18[31:18] = 0;
        field { sw = rw; hw = w; onwrite = woclr; desc = "Write-transaction watchdog expired for RP0: with wdt_en set, no AW or B handshake for wdt_threshold cycles while writes were outstanding (AW accepted, B from the remote die not yet received). Set by HW, write 1 to clear. Raises INT_EARLY_WDT_ERR unless masked. The watchdog fires once per reset: after a timeout it does not re-arm until I_RESETN or AOU_SW_RESET."; } wdt_trans_timeout_err[17:17] = 0;
        field { sw = rw; desc = "Enable the early-response write-transaction watchdog for RP0."; } wdt_en[16:16] = 0;
        field { sw = rw; desc = "Return the early write response for every non-exclusive write on RP0, regardless of AWCACHE[0] (Bufferable). Exclusive writes (AWLOCK = 1) never receive an early response."; } early_always_en[15:15] = 0;
        field { sw = r; hw = w; desc = "Write response completion status for RP0. Read-only, driven by HW."; } write_resp_done[14:14];
        field { sw = rw; hw = w; onwrite = woclr; desc = "Early write response error for RP0. Set by HW, write 1 to clear."; } write_resp_err[13:13] = 0;
        field { sw = r; hw = rw; desc = "Captured BRESP type when early write response error occurs. Clears when error clears."; } write_resp_err_type_info[12:11];
        field { sw = r; hw = rw; desc = "Captured BID when early write response error occurs. Clears when error clears."; } write_resp_err_id_info[10:1];
        field { sw = rw; desc = "Enable early BRESP (write response before data is committed) for RP0."; } early_bresp_en[0:0] = 0;
    } write_early_response_rp0 @ 0x0028;

    reg {
        regwidth = 32;
        name = "AXI Error Info0 RP0";
        desc = "Debug address register (upper) for RP0.";
        field { sw = rw; desc = "Upper 32 bits of the dedicated AXI address used to access R/B response error debug information for RP0. Set this address along with debug_lower_addr and error_info_access_en to enable error information readout by the remote die via AXI read. Up to 4 entries are held, one per failing manager-port B or R beat; the remote die reads the head entry with a single-beat read of this address and pops it with a single-beat write of any data to it."; } debug_upper_addr[31:0] = 0;
    } axi_error_info0_rp0 @ 0x002C;

    reg {
        regwidth = 32;
        name = "AXI Error Info1 RP0";
        desc = "Debug address register (lower) for RP0.";
        field { sw = rw; desc = "Bits [31:7] of the dedicated AXI address used to access R/B response error debug information for RP0. Together with debug_upper_addr, defines the target address for error information access. Bits [6:0] of the address are reserved and read as zero, so the address is 128-byte aligned: an access to a debug address not aligned to its AxSIZE would miss the window, and one narrower than the RP not aligned to the RP's width would read zeros."; } debug_lower_addr[31:7] = 0;
        field { sw = r; } reserved_6_0[6:0] = 0;
    } axi_error_info1_rp0 @ 0x0030;

    reg {
        regwidth = 32;
        name = "AXI Slave ID Mismatch Error RP0";
        desc = "AXI slave BID/RID mismatch checker enable, captured ID and error flags for RP0. AXI_SLV_ID_MISMATCH_EN is static configuration: program it only while the activation FSM is DISABLED and this RP has no AXI traffic outstanding.";
        field { sw = r; } reserved_31_23[31:23] = 0;
        field { sw = rw; desc = "Enable the subordinate-port AXI ID-mismatch checker on this RP. Reset 0: the checker sees no handshakes, the error bits stay 0 and this RP does not raise INT_SI0_ID_MISMATCH. Set to 1 to report a B or R whose ID matches no outstanding request on this subordinate port. Write this bit only while the activation FSM is DISABLED and no AXI traffic is outstanding on this RP. Do not change it while AXI transactions are in flight: the checker records handshakes only while the enable is set."; } axi_slv_id_mismatch_en[22:22] = 0;
        field { sw = r; hw = rw; desc = "Captured BID when an AXI slave BID mismatch occurs. Clears when error clears."; } axi_slv_bid_mismatch_info[21:12];
        field { sw = r; hw = rw; desc = "Captured RID when an AXI slave RID mismatch occurs. Clears when error clears."; } axi_slv_rid_mismatch_info[11:2];
        field { sw = rw; hw = w; onwrite = woclr; desc = "AXI slave BID mismatch error. Set by HW, write 1 to clear."; } axi_slv_bid_mismatch_err[1:1] = 0;
        field { sw = rw; hw = w; onwrite = woclr; desc = "AXI slave RID mismatch error. Set by HW, write 1 to clear."; } axi_slv_rid_mismatch_err[0:0] = 0;
    } axi_slv_id_mismatch_err_rp0 @ 0x0034;

    // -------------------------------------------------------------------------
    // RP1
    // -------------------------------------------------------------------------
    reg {
        regwidth = 32;
        name = "AXI Split Transaction RP1";
        desc = "Maximum AXI burst lengths for split transactions on Resource Plane 1.";
        field { sw = r; } reserved_31_16[31:16] = 0;
        field { sw = rw; desc = "Maximum AXI write burst length for split transactions on RP1. Legal values are 2^n - 1: 0, 1, 3, 7, 15, 31, 63, 127, 255. Any other written value is stored as 0xF (16 beats)."; } max_awburstlen[15:8] = 0xF;
        field { sw = rw; desc = "Maximum AXI read burst length for split transactions on RP1. Legal values are 2^n - 1: 0, 1, 3, 7, 15, 31, 63, 127, 255. Any other written value is stored as 0xF (16 beats)."; } max_arburstlen[7:0] = 0xF;
    } axi_split_tr_rp1 @ 0x0038;

    reg {
        regwidth = 32;
        name = "Error Info RP1";
        desc = "Split transaction BID/RID mismatch info and error flags for RP1.";
        field { sw = r; } reserved_31_22[31:22] = 0;
        field { sw = r; hw = rw; desc = "Captured BID when a split transaction BID mismatch occurs. Clears when error clears."; } split_bid_mismatch_info[21:12];
        field { sw = r; hw = rw; desc = "Captured RID when a split transaction RID mismatch occurs. Clears when error clears."; } split_rid_mismatch_info[11:2];
        field { sw = rw; hw = w; onwrite = woclr; desc = "Split transaction BID mismatch error. Set by HW, write 1 to clear."; } split_bid_mismatch_err[1:1] = 0;
        field { sw = rw; hw = w; onwrite = woclr; desc = "Split transaction RID mismatch error. Set by HW, write 1 to clear."; } split_rid_mismatch_err[0:0] = 0;
    } error_info_rp1 @ 0x003C;

    reg {
        regwidth = 32;
        name = "Write Early Response RP1";
        desc = "Write response done/error status, early BRESP enable and write-transaction watchdog control for RP1.";
        field { sw = r; } reserved_31_18[31:18] = 0;
        field { sw = rw; hw = w; onwrite = woclr; desc = "Write-transaction watchdog expired for RP1: with wdt_en set, no AW or B handshake for wdt_threshold cycles while writes were outstanding (AW accepted, B from the remote die not yet received). Set by HW, write 1 to clear. Raises INT_EARLY_WDT_ERR unless masked. The watchdog fires once per reset: after a timeout it does not re-arm until I_RESETN or AOU_SW_RESET."; } wdt_trans_timeout_err[17:17] = 0;
        field { sw = rw; desc = "Enable the early-response write-transaction watchdog for RP1."; } wdt_en[16:16] = 0;
        field { sw = rw; desc = "Return the early write response for every non-exclusive write on RP1, regardless of AWCACHE[0] (Bufferable). Exclusive writes (AWLOCK = 1) never receive an early response."; } early_always_en[15:15] = 0;
        field { sw = r; hw = w; desc = "Write response completion status for RP1. Read-only, driven by HW."; } write_resp_done[14:14];
        field { sw = rw; hw = w; onwrite = woclr; desc = "Early write response error for RP1. Set by HW, write 1 to clear."; } write_resp_err[13:13] = 0;
        field { sw = r; hw = rw; desc = "Captured BRESP type when early write response error occurs. Clears when error clears."; } write_resp_err_type_info[12:11];
        field { sw = r; hw = rw; desc = "Captured BID when early write response error occurs. Clears when error clears."; } write_resp_err_id_info[10:1];
        field { sw = rw; desc = "Enable early BRESP (write response before data is committed) for RP1."; } early_bresp_en[0:0] = 0;
    } write_early_response_rp1 @ 0x0040;

    reg {
        regwidth = 32;
        name = "AXI Error Info0 RP1";
        desc = "Debug address register (upper) for RP1.";
        field { sw = rw; desc = "Upper 32 bits of the dedicated AXI address used to access R/B response error debug information for RP1. Set this address along with debug_lower_addr and error_info_access_en to enable error information readout by the remote die via AXI read. Up to 4 entries are held, one per failing manager-port B or R beat; the remote die reads the head entry with a single-beat read of this address and pops it with a single-beat write of any data to it."; } debug_upper_addr[31:0] = 0;
    } axi_error_info0_rp1 @ 0x0044;

    reg {
        regwidth = 32;
        name = "AXI Error Info1 RP1";
        desc = "Debug address register (lower) for RP1.";
        field { sw = rw; desc = "Bits [31:7] of the dedicated AXI address used to access R/B response error debug information for RP1. Together with debug_upper_addr, defines the target address for error information access. Bits [6:0] of the address are reserved and read as zero, so the address is 128-byte aligned: an access to a debug address not aligned to its AxSIZE would miss the window, and one narrower than the RP not aligned to the RP's width would read zeros."; } debug_lower_addr[31:7] = 0;
        field { sw = r; } reserved_6_0[6:0] = 0;
    } axi_error_info1_rp1 @ 0x0048;

    reg {
        regwidth = 32;
        name = "AXI Slave ID Mismatch Error RP1";
        desc = "AXI slave BID/RID mismatch checker enable, captured ID and error flags for RP1. AXI_SLV_ID_MISMATCH_EN is static configuration: program it only while the activation FSM is DISABLED and this RP has no AXI traffic outstanding.";
        field { sw = r; } reserved_31_23[31:23] = 0;
        field { sw = rw; desc = "Enable the subordinate-port AXI ID-mismatch checker on this RP. Reset 0: the checker sees no handshakes, the error bits stay 0 and this RP does not raise INT_SI0_ID_MISMATCH. Set to 1 to report a B or R whose ID matches no outstanding request on this subordinate port. Write this bit only while the activation FSM is DISABLED and no AXI traffic is outstanding on this RP. Do not change it while AXI transactions are in flight: the checker records handshakes only while the enable is set."; } axi_slv_id_mismatch_en[22:22] = 0;
        field { sw = r; hw = rw; desc = "Captured BID when an AXI slave BID mismatch occurs. Clears when error clears."; } axi_slv_bid_mismatch_info[21:12];
        field { sw = r; hw = rw; desc = "Captured RID when an AXI slave RID mismatch occurs. Clears when error clears."; } axi_slv_rid_mismatch_info[11:2];
        field { sw = rw; hw = w; onwrite = woclr; desc = "AXI slave BID mismatch error. Set by HW, write 1 to clear."; } axi_slv_bid_mismatch_err[1:1] = 0;
        field { sw = rw; hw = w; onwrite = woclr; desc = "AXI slave RID mismatch error. Set by HW, write 1 to clear."; } axi_slv_rid_mismatch_err[0:0] = 0;
    } axi_slv_id_mismatch_err_rp1 @ 0x004C;

    // -------------------------------------------------------------------------
    // RP2
    // -------------------------------------------------------------------------
    reg {
        regwidth = 32;
        name = "AXI Split Transaction RP2";
        desc = "Maximum AXI burst lengths for split transactions on Resource Plane 2.";
        field { sw = r; } reserved_31_16[31:16] = 0;
        field { sw = rw; desc = "Maximum AXI write burst length for split transactions on RP2. Legal values are 2^n - 1: 0, 1, 3, 7, 15, 31, 63, 127, 255. Any other written value is stored as 0xF (16 beats)."; } max_awburstlen[15:8] = 0xF;
        field { sw = rw; desc = "Maximum AXI read burst length for split transactions on RP2. Legal values are 2^n - 1: 0, 1, 3, 7, 15, 31, 63, 127, 255. Any other written value is stored as 0xF (16 beats)."; } max_arburstlen[7:0] = 0xF;
    } axi_split_tr_rp2 @ 0x0050;

    reg {
        regwidth = 32;
        name = "Error Info RP2";
        desc = "Split transaction BID/RID mismatch info and error flags for RP2.";
        field { sw = r; } reserved_31_22[31:22] = 0;
        field { sw = r; hw = rw; desc = "Captured BID when a split transaction BID mismatch occurs. Clears when error clears."; } split_bid_mismatch_info[21:12];
        field { sw = r; hw = rw; desc = "Captured RID when a split transaction RID mismatch occurs. Clears when error clears."; } split_rid_mismatch_info[11:2];
        field { sw = rw; hw = w; onwrite = woclr; desc = "Split transaction BID mismatch error. Set by HW, write 1 to clear."; } split_bid_mismatch_err[1:1] = 0;
        field { sw = rw; hw = w; onwrite = woclr; desc = "Split transaction RID mismatch error. Set by HW, write 1 to clear."; } split_rid_mismatch_err[0:0] = 0;
    } error_info_rp2 @ 0x0054;

    reg {
        regwidth = 32;
        name = "Write Early Response RP2";
        desc = "Write response done/error status, early BRESP enable and write-transaction watchdog control for RP2.";
        field { sw = r; } reserved_31_18[31:18] = 0;
        field { sw = rw; hw = w; onwrite = woclr; desc = "Write-transaction watchdog expired for RP2: with wdt_en set, no AW or B handshake for wdt_threshold cycles while writes were outstanding (AW accepted, B from the remote die not yet received). Set by HW, write 1 to clear. Raises INT_EARLY_WDT_ERR unless masked. The watchdog fires once per reset: after a timeout it does not re-arm until I_RESETN or AOU_SW_RESET."; } wdt_trans_timeout_err[17:17] = 0;
        field { sw = rw; desc = "Enable the early-response write-transaction watchdog for RP2."; } wdt_en[16:16] = 0;
        field { sw = rw; desc = "Return the early write response for every non-exclusive write on RP2, regardless of AWCACHE[0] (Bufferable). Exclusive writes (AWLOCK = 1) never receive an early response."; } early_always_en[15:15] = 0;
        field { sw = r; hw = w; desc = "Write response completion status for RP2. Read-only, driven by HW."; } write_resp_done[14:14];
        field { sw = rw; hw = w; onwrite = woclr; desc = "Early write response error for RP2. Set by HW, write 1 to clear."; } write_resp_err[13:13] = 0;
        field { sw = r; hw = rw; desc = "Captured BRESP type when early write response error occurs. Clears when error clears."; } write_resp_err_type_info[12:11];
        field { sw = r; hw = rw; desc = "Captured BID when early write response error occurs. Clears when error clears."; } write_resp_err_id_info[10:1];
        field { sw = rw; desc = "Enable early BRESP (write response before data is committed) for RP2."; } early_bresp_en[0:0] = 0;
    } write_early_response_rp2 @ 0x0058;

    reg {
        regwidth = 32;
        name = "AXI Error Info0 RP2";
        desc = "Debug address register (upper) for RP2.";
        field { sw = rw; desc = "Upper 32 bits of the dedicated AXI address used to access R/B response error debug information for RP2. Set this address along with debug_lower_addr and error_info_access_en to enable error information readout by the remote die via AXI read. Up to 4 entries are held, one per failing manager-port B or R beat; the remote die reads the head entry with a single-beat read of this address and pops it with a single-beat write of any data to it."; } debug_upper_addr[31:0] = 0;
    } axi_error_info0_rp2 @ 0x005C;

    reg {
        regwidth = 32;
        name = "AXI Error Info1 RP2";
        desc = "Debug address register (lower) for RP2.";
        field { sw = rw; desc = "Bits [31:7] of the dedicated AXI address used to access R/B response error debug information for RP2. Together with debug_upper_addr, defines the target address for error information access. Bits [6:0] of the address are reserved and read as zero, so the address is 128-byte aligned: an access to a debug address not aligned to its AxSIZE would miss the window, and one narrower than the RP not aligned to the RP's width would read zeros."; } debug_lower_addr[31:7] = 0;
        field { sw = r; } reserved_6_0[6:0] = 0;
    } axi_error_info1_rp2 @ 0x0060;

    reg {
        regwidth = 32;
        name = "AXI Slave ID Mismatch Error RP2";
        desc = "AXI slave BID/RID mismatch checker enable, captured ID and error flags for RP2. AXI_SLV_ID_MISMATCH_EN is static configuration: program it only while the activation FSM is DISABLED and this RP has no AXI traffic outstanding.";
        field { sw = r; } reserved_31_23[31:23] = 0;
        field { sw = rw; desc = "Enable the subordinate-port AXI ID-mismatch checker on this RP. Reset 0: the checker sees no handshakes, the error bits stay 0 and this RP does not raise INT_SI0_ID_MISMATCH. Set to 1 to report a B or R whose ID matches no outstanding request on this subordinate port. Write this bit only while the activation FSM is DISABLED and no AXI traffic is outstanding on this RP. Do not change it while AXI transactions are in flight: the checker records handshakes only while the enable is set."; } axi_slv_id_mismatch_en[22:22] = 0;
        field { sw = r; hw = rw; desc = "Captured BID when an AXI slave BID mismatch occurs. Clears when error clears."; } axi_slv_bid_mismatch_info[21:12];
        field { sw = r; hw = rw; desc = "Captured RID when an AXI slave RID mismatch occurs. Clears when error clears."; } axi_slv_rid_mismatch_info[11:2];
        field { sw = rw; hw = w; onwrite = woclr; desc = "AXI slave BID mismatch error. Set by HW, write 1 to clear."; } axi_slv_bid_mismatch_err[1:1] = 0;
        field { sw = rw; hw = w; onwrite = woclr; desc = "AXI slave RID mismatch error. Set by HW, write 1 to clear."; } axi_slv_rid_mismatch_err[0:0] = 0;
    } axi_slv_id_mismatch_err_rp2 @ 0x0064;

    // -------------------------------------------------------------------------
    // RP3
    // -------------------------------------------------------------------------
    reg {
        regwidth = 32;
        name = "AXI Split Transaction RP3";
        desc = "Maximum AXI burst lengths for split transactions on Resource Plane 3.";
        field { sw = r; } reserved_31_16[31:16] = 0;
        field { sw = rw; desc = "Maximum AXI write burst length for split transactions on RP3. Legal values are 2^n - 1: 0, 1, 3, 7, 15, 31, 63, 127, 255. Any other written value is stored as 0xF (16 beats)."; } max_awburstlen[15:8] = 0xF;
        field { sw = rw; desc = "Maximum AXI read burst length for split transactions on RP3. Legal values are 2^n - 1: 0, 1, 3, 7, 15, 31, 63, 127, 255. Any other written value is stored as 0xF (16 beats)."; } max_arburstlen[7:0] = 0xF;
    } axi_split_tr_rp3 @ 0x0068;

    reg {
        regwidth = 32;
        name = "Error Info RP3";
        desc = "Split transaction BID/RID mismatch info and error flags for RP3.";
        field { sw = r; } reserved_31_22[31:22] = 0;
        field { sw = r; hw = rw; desc = "Captured BID when a split transaction BID mismatch occurs. Clears when error clears."; } split_bid_mismatch_info[21:12];
        field { sw = r; hw = rw; desc = "Captured RID when a split transaction RID mismatch occurs. Clears when error clears."; } split_rid_mismatch_info[11:2];
        field { sw = rw; hw = w; onwrite = woclr; desc = "Split transaction BID mismatch error. Set by HW, write 1 to clear."; } split_bid_mismatch_err[1:1] = 0;
        field { sw = rw; hw = w; onwrite = woclr; desc = "Split transaction RID mismatch error. Set by HW, write 1 to clear."; } split_rid_mismatch_err[0:0] = 0;
    } error_info_rp3 @ 0x006C;

    reg {
        regwidth = 32;
        name = "Write Early Response RP3";
        desc = "Write response done/error status, early BRESP enable and write-transaction watchdog control for RP3.";
        field { sw = r; } reserved_31_18[31:18] = 0;
        field { sw = rw; hw = w; onwrite = woclr; desc = "Write-transaction watchdog expired for RP3: with wdt_en set, no AW or B handshake for wdt_threshold cycles while writes were outstanding (AW accepted, B from the remote die not yet received). Set by HW, write 1 to clear. Raises INT_EARLY_WDT_ERR unless masked. The watchdog fires once per reset: after a timeout it does not re-arm until I_RESETN or AOU_SW_RESET."; } wdt_trans_timeout_err[17:17] = 0;
        field { sw = rw; desc = "Enable the early-response write-transaction watchdog for RP3."; } wdt_en[16:16] = 0;
        field { sw = rw; desc = "Return the early write response for every non-exclusive write on RP3, regardless of AWCACHE[0] (Bufferable). Exclusive writes (AWLOCK = 1) never receive an early response."; } early_always_en[15:15] = 0;
        field { sw = r; hw = w; desc = "Write response completion status for RP3. Read-only, driven by HW."; } write_resp_done[14:14];
        field { sw = rw; hw = w; onwrite = woclr; desc = "Early write response error for RP3. Set by HW, write 1 to clear."; } write_resp_err[13:13] = 0;
        field { sw = r; hw = rw; desc = "Captured BRESP type when early write response error occurs. Clears when error clears."; } write_resp_err_type_info[12:11];
        field { sw = r; hw = rw; desc = "Captured BID when early write response error occurs. Clears when error clears."; } write_resp_err_id_info[10:1];
        field { sw = rw; desc = "Enable early BRESP (write response before data is committed) for RP3."; } early_bresp_en[0:0] = 0;
    } write_early_response_rp3 @ 0x0070;

    reg {
        regwidth = 32;
        name = "AXI Error Info0 RP3";
        desc = "Debug address register (upper) for RP3.";
        field { sw = rw; desc = "Upper 32 bits of the dedicated AXI address used to access R/B response error debug information for RP3. Set this address along with debug_lower_addr and error_info_access_en to enable error information readout by the remote die via AXI read. Up to 4 entries are held, one per failing manager-port B or R beat; the remote die reads the head entry with a single-beat read of this address and pops it with a single-beat write of any data to it."; } debug_upper_addr[31:0] = 0;
    } axi_error_info0_rp3 @ 0x0074;

    reg {
        regwidth = 32;
        name = "AXI Error Info1 RP3";
        desc = "Debug address register (lower) for RP3.";
        field { sw = rw; desc = "Bits [31:7] of the dedicated AXI address used to access R/B response error debug information for RP3. Together with debug_upper_addr, defines the target address for error information access. Bits [6:0] of the address are reserved and read as zero, so the address is 128-byte aligned: an access to a debug address not aligned to its AxSIZE would miss the window, and one narrower than the RP not aligned to the RP's width would read zeros."; } debug_lower_addr[31:7] = 0;
        field { sw = r; } reserved_6_0[6:0] = 0;
    } axi_error_info1_rp3 @ 0x0078;

    reg {
        regwidth = 32;
        name = "AXI Slave ID Mismatch Error RP3";
        desc = "AXI slave BID/RID mismatch checker enable, captured ID and error flags for RP3. AXI_SLV_ID_MISMATCH_EN is static configuration: program it only while the activation FSM is DISABLED and this RP has no AXI traffic outstanding.";
        field { sw = r; } reserved_31_23[31:23] = 0;
        field { sw = rw; desc = "Enable the subordinate-port AXI ID-mismatch checker on this RP. Reset 0: the checker sees no handshakes, the error bits stay 0 and this RP does not raise INT_SI0_ID_MISMATCH. Set to 1 to report a B or R whose ID matches no outstanding request on this subordinate port. Write this bit only while the activation FSM is DISABLED and no AXI traffic is outstanding on this RP. Do not change it while AXI transactions are in flight: the checker records handshakes only while the enable is set."; } axi_slv_id_mismatch_en[22:22] = 0;
        field { sw = r; hw = rw; desc = "Captured BID when an AXI slave BID mismatch occurs. Clears when error clears."; } axi_slv_bid_mismatch_info[21:12];
        field { sw = r; hw = rw; desc = "Captured RID when an AXI slave RID mismatch occurs. Clears when error clears."; } axi_slv_rid_mismatch_info[11:2];
        field { sw = rw; hw = w; onwrite = woclr; desc = "AXI slave BID mismatch error. Set by HW, write 1 to clear."; } axi_slv_bid_mismatch_err[1:1] = 0;
        field { sw = rw; hw = w; onwrite = woclr; desc = "AXI slave RID mismatch error. Set by HW, write 1 to clear."; } axi_slv_rid_mismatch_err[0:0] = 0;
    } axi_slv_id_mismatch_err_rp3 @ 0x007C;

    // -------------------------------------------------------------------------
    // Write Early Response Watchdog Control (shared by all RPs)
    // -------------------------------------------------------------------------
    reg {
        regwidth = 32;
        name = "Write Early Response WDT Control";
        desc = "Threshold of the early-response write-transaction watchdog, shared by all RPs. Each RP's watchdog is enabled by write_early_response_rpN.wdt_en and reports through write_early_response_rpN.wdt_trans_timeout_err.";
        field { sw = rw; desc = "Watchdog threshold in I_CLK cycles. The watchdog counts cycles without an AW or B handshake while writes are outstanding (AW accepted, B from the remote die not yet received) and restarts on either handshake; reaching the threshold sets wdt_trans_timeout_err once per reset. Reset 0xC3500 = 800000 cycles (800 us at 1 GHz)."; } wdt_threshold[31:0] = 0xC3500;
    } write_early_response_wdt_ctl @ 0x0080;
};
